ADE simulation setup
Run mode: Monte Carlo Sampling
Tests:
  daisyDemo:daisyAmpOffset_T:1: daisyDemo/daisyAmpOffset_T/schematic, simulator spectre
Global variables:
  Acomp = 1000
  fClk = 1e6
  vccr = 1
  vCom = 1
  vDiff = 0
  tStop = NOC/fClk
  NOC = 13
Monte Carlo Sampling options: mcmethod=all, mcnumpoints=10
