(printf " ... loading %s.il ...\n" "pwlGen")

(defun daisyGenPwl
  (@key
   (fileName     "~/input.pwl")
   (sampleTime    4n)
   (timePeriod    12u)
   (blankingTime  200n)
   (blankingLevel 0.0)
   (repeatFrom    0.0)
   (dc            0.0)
   (delay         0.0)
   (amplitude     1.0)
   (frequency     10.1319191M)
   (posNode  "netP")
   (negNode  "netN")
   (srcName  "I0") )

  ;; Signal starts with blanking period.
  ;; Then it generates random signal from blankingTime to timePeriod.

  (let ( (timeStamp 0.0n)
	 (yVal 0.0)
	 (PI 3.1415926535897932385))
    (setq oport (outfile fileName))
    (if oport
	(progn
	  (fprintf oport "* This file is automatically generated.\n")
	  (fprintf oport "* Update your stimulus.cir file to include it.\n")
	  (fprintf oport "* .include %s \n" fileName)
	  (fprintf oport "%s %s %s PWL( \n" srcName posNode negNode)
	  (while (timeStamp < timePeriod)
	    (if (timeStamp <= blankingTime)
		(setq yVal (float blankingLevel))
	      (setq yVal (float (float dc)+(float amplitude)*(sin 2*PI*(float frequency)*(float timeStamp)))))
	    (fprintf oport "+ %1.12f %6.6f\n"  timeStamp yVal)
	    (setq timeStamp (plus timeStamp sampleTime))
	    (if timeStamp >= timePeriod
		(progn
		  (setq yVal (float (float dc)+(float amplitude)*(sin 2*PI*(float frequency)*(float timePeriod))))
		  (fprintf oport "+ %1.12f %6.6f\n"  timePeriod yVal)
		  (fprintf oport "+ R=%1.12f SHIFT=%1.12f )" (float repeatFrom) (float delay) )))))))
  (close oport)
  (view fileName nil (strcat "PWL files")))

(defun daisyMimicPwl ()
  (let ((selectedObjects (geGetSelectedSet))
	(fileName    ""     )
	(repeatFrom  0      )
	(delay       0      )
	(posNode     ""     )
	(negNode     ""     )
	(srcName     ""     )
	(sampleTime  4n)
	(duration   12u)
	(blankTime  200n)
	(blankLevel 0.0)
	(dc         0.0)
	(amplitude 1)
	(frequency 10.111929121M))
    (foreach object selectedObjects
	     (if (equal object->cellName "vpwlf")
		 (progn
		   (setq instName object->name)
		   (foreach prop object->prop
			    (if (equal prop->name "Td")
				(setq delay (evalstring prop->value)))
			    (if (equal prop->name "r")
				(setq repeatFrom (evalstring prop->value)))
			    (if (equal prop->name "file")
				(setq fileName prop->value))
			    (if (equal prop->name "sampleTime")
				(setq sampleTime (evalstring prop->value)))
			    (if (equal prop->name "duration")
				(setq duration (evalstring prop->value)))
			    (if (equal prop->name "blankTime")
				(setq blankTime (evalstring prop->value)))
			    (if (equal prop->name "blankLevel")
				(setq blankLevel (evalstring prop->value)))
			    (if (equal prop->name "dc")
				(setq dc (evalstring prop->value)))
			    (if (equal prop->name "amplitude")
				(setq amplitude (evalstring prop->value)))
			    (if (equal prop->name "frequency")
				(setq frequency (evalstring prop->value))))
		   (foreach term object->instTerms
			    (if (equal term->name "plus")
				(setq posNode term->net->name)
			      (setq negNode term->net->name)))
		   (daisyGenPwl
		    ?fileName      fileName
		    ?repeatFrom    repeatFrom
		    ?delay         delay
		    ?posNode      posNode
		    ?negNode      negNode
		    ?srcName      (strcat "V" instName)
		    ;; The following could be added by using user properties on the
		    ;; different sources.
		    ?sampleTime    sampleTime
		    ?timePeriod    duration
		    ?blankingTime  blankTime
		    ?blankingLevel  blankLevel
		    ?dc            dc
		    ?amplitude     amplitude
		    ?frequency     frequency))))))
