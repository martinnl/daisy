;
;;;;;;;;;;;;;;;;;;;;;;;;;; GUI builder information ;;;;;;;;;;;;;;;;;;;;;;;;;;;
ocnmRegGUIBuilder(
 '(nil
  function abMovingAvg
  name abMovingAvg
  description "abMovingAvg"
  category ("Custom Functions")
  analysis (nil
      general (nil
        args (waveform timeWindow gain )
          signals (nil
                waveform (nil
                      prompt "waveform"
                      tooltip "waveform"
                      )
           )
          params(nil
                 timeWindow (nil
                       prompt "timeWindow"
                       tooltip "timeWindow"
                       guiRowHint 1
                       type float
                       default 100u
                       required t
                 )
                 gain (nil
                       prompt "gain"
                       tooltip "gain"
                       guiRowHint 2
                       type int
                       default 1
                       required nil
                 )
          )
        inputrange t
      )
  )
  outputs(result)
 )
)
